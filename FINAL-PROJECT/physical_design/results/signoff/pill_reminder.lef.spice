* NGSPICE file created from pill_reminder.ext - technology: sky130A

* Black-box entry subcircuit for sky130_fd_sc_hd__fill_1 abstract view
.subckt sky130_fd_sc_hd__fill_1 VGND VNB VPB VPWR
.ends

* Black-box entry subcircuit for sky130_ef_sc_hd__decap_12 abstract view
.subckt sky130_ef_sc_hd__decap_12 VPWR VGND VPB VNB
.ends

* Black-box entry subcircuit for sky130_fd_sc_hd__nor2_1 abstract view
.subckt sky130_fd_sc_hd__nor2_1 A B VGND VNB VPB VPWR Y
.ends

* Black-box entry subcircuit for sky130_fd_sc_hd__o21a_1 abstract view
.subckt sky130_fd_sc_hd__o21a_1 A1 A2 B1 VGND VNB VPB VPWR X
.ends

* Black-box entry subcircuit for sky130_fd_sc_hd__decap_6 abstract view
.subckt sky130_fd_sc_hd__decap_6 VGND VNB VPB VPWR
.ends

* Black-box entry subcircuit for sky130_fd_sc_hd__tapvpwrvgnd_1 abstract view
.subckt sky130_fd_sc_hd__tapvpwrvgnd_1 VGND VPWR
.ends

* Black-box entry subcircuit for sky130_fd_sc_hd__decap_4 abstract view
.subckt sky130_fd_sc_hd__decap_4 VGND VNB VPB VPWR
.ends

* Black-box entry subcircuit for sky130_fd_sc_hd__clkbuf_2 abstract view
.subckt sky130_fd_sc_hd__clkbuf_2 A VGND VNB VPB VPWR X
.ends

* Black-box entry subcircuit for sky130_fd_sc_hd__decap_3 abstract view
.subckt sky130_fd_sc_hd__decap_3 VGND VNB VPB VPWR
.ends

* Black-box entry subcircuit for sky130_fd_sc_hd__or2b_1 abstract view
.subckt sky130_fd_sc_hd__or2b_1 A B_N VGND VNB VPB VPWR X
.ends

* Black-box entry subcircuit for sky130_fd_sc_hd__dfxtp_1 abstract view
.subckt sky130_fd_sc_hd__dfxtp_1 CLK D VGND VNB VPB VPWR Q
.ends

* Black-box entry subcircuit for sky130_fd_sc_hd__decap_8 abstract view
.subckt sky130_fd_sc_hd__decap_8 VGND VNB VPB VPWR
.ends

* Black-box entry subcircuit for sky130_fd_sc_hd__fill_2 abstract view
.subckt sky130_fd_sc_hd__fill_2 VGND VNB VPB VPWR
.ends

* Black-box entry subcircuit for sky130_fd_sc_hd__o21ai_1 abstract view
.subckt sky130_fd_sc_hd__o21ai_1 A1 A2 B1 VGND VNB VPB VPWR Y
.ends

* Black-box entry subcircuit for sky130_fd_sc_hd__clkinvlp_4 abstract view
.subckt sky130_fd_sc_hd__clkinvlp_4 A VGND VNB VPB VPWR Y
.ends

* Black-box entry subcircuit for sky130_fd_sc_hd__a21oi_1 abstract view
.subckt sky130_fd_sc_hd__a21oi_1 A1 A2 B1 VGND VNB VPB VPWR Y
.ends

* Black-box entry subcircuit for sky130_fd_sc_hd__a22o_1 abstract view
.subckt sky130_fd_sc_hd__a22o_1 A1 A2 B1 B2 VGND VNB VPB VPWR X
.ends

* Black-box entry subcircuit for sky130_fd_sc_hd__or2_1 abstract view
.subckt sky130_fd_sc_hd__or2_1 A B VGND VNB VPB VPWR X
.ends

* Black-box entry subcircuit for sky130_fd_sc_hd__clkbuf_1 abstract view
.subckt sky130_fd_sc_hd__clkbuf_1 A VGND VNB VPB VPWR X
.ends

* Black-box entry subcircuit for sky130_fd_sc_hd__or3_1 abstract view
.subckt sky130_fd_sc_hd__or3_1 A B C VGND VNB VPB VPWR X
.ends

* Black-box entry subcircuit for sky130_fd_sc_hd__and2b_1 abstract view
.subckt sky130_fd_sc_hd__and2b_1 A_N B VGND VNB VPB VPWR X
.ends

* Black-box entry subcircuit for sky130_fd_sc_hd__clkbuf_16 abstract view
.subckt sky130_fd_sc_hd__clkbuf_16 A VGND VNB VPB VPWR X
.ends

* Black-box entry subcircuit for sky130_fd_sc_hd__a211oi_1 abstract view
.subckt sky130_fd_sc_hd__a211oi_1 A1 A2 B1 C1 VGND VNB VPB VPWR Y
.ends

* Black-box entry subcircuit for sky130_fd_sc_hd__and2_1 abstract view
.subckt sky130_fd_sc_hd__and2_1 A B VGND VNB VPB VPWR X
.ends

* Black-box entry subcircuit for sky130_fd_sc_hd__o211ai_4 abstract view
.subckt sky130_fd_sc_hd__o211ai_4 A1 A2 B1 C1 VGND VNB VPB VPWR Y
.ends

* Black-box entry subcircuit for sky130_fd_sc_hd__a31oi_1 abstract view
.subckt sky130_fd_sc_hd__a31oi_1 A1 A2 A3 B1 VGND VNB VPB VPWR Y
.ends

* Black-box entry subcircuit for sky130_fd_sc_hd__or4_1 abstract view
.subckt sky130_fd_sc_hd__or4_1 A B C D VGND VNB VPB VPWR X
.ends

* Black-box entry subcircuit for sky130_fd_sc_hd__a21o_1 abstract view
.subckt sky130_fd_sc_hd__a21o_1 A1 A2 B1 VGND VNB VPB VPWR X
.ends

* Black-box entry subcircuit for sky130_fd_sc_hd__inv_2 abstract view
.subckt sky130_fd_sc_hd__inv_2 A VGND VNB VPB VPWR Y
.ends

* Black-box entry subcircuit for sky130_fd_sc_hd__a41o_1 abstract view
.subckt sky130_fd_sc_hd__a41o_1 A1 A2 A3 A4 B1 VGND VNB VPB VPWR X
.ends

* Black-box entry subcircuit for sky130_fd_sc_hd__nand2_1 abstract view
.subckt sky130_fd_sc_hd__nand2_1 A B VGND VNB VPB VPWR Y
.ends

* Black-box entry subcircuit for sky130_fd_sc_hd__and4_1 abstract view
.subckt sky130_fd_sc_hd__and4_1 A B C D VGND VNB VPB VPWR X
.ends

* Black-box entry subcircuit for sky130_fd_sc_hd__and3_1 abstract view
.subckt sky130_fd_sc_hd__and3_1 A B C VGND VNB VPB VPWR X
.ends

* Black-box entry subcircuit for sky130_fd_sc_hd__a31o_1 abstract view
.subckt sky130_fd_sc_hd__a31o_1 A1 A2 A3 B1 VGND VNB VPB VPWR X
.ends

* Black-box entry subcircuit for sky130_fd_sc_hd__buf_1 abstract view
.subckt sky130_fd_sc_hd__buf_1 A VGND VNB VPB VPWR X
.ends

* Black-box entry subcircuit for sky130_fd_sc_hd__o211a_1 abstract view
.subckt sky130_fd_sc_hd__o211a_1 A1 A2 B1 C1 VGND VNB VPB VPWR X
.ends

* Black-box entry subcircuit for sky130_fd_sc_hd__buf_2 abstract view
.subckt sky130_fd_sc_hd__buf_2 A VGND VNB VPB VPWR X
.ends

* Black-box entry subcircuit for sky130_fd_sc_hd__o311a_1 abstract view
.subckt sky130_fd_sc_hd__o311a_1 A1 A2 A3 B1 C1 VGND VNB VPB VPWR X
.ends

* Black-box entry subcircuit for sky130_fd_sc_hd__a21boi_1 abstract view
.subckt sky130_fd_sc_hd__a21boi_1 A1 A2 B1_N VGND VNB VPB VPWR Y
.ends

* Black-box entry subcircuit for sky130_fd_sc_hd__nor4_1 abstract view
.subckt sky130_fd_sc_hd__nor4_1 A B C D VGND VNB VPB VPWR Y
.ends

* Black-box entry subcircuit for sky130_fd_sc_hd__and3b_1 abstract view
.subckt sky130_fd_sc_hd__and3b_1 A_N B C VGND VNB VPB VPWR X
.ends

* Black-box entry subcircuit for sky130_fd_sc_hd__nor3_1 abstract view
.subckt sky130_fd_sc_hd__nor3_1 A B C VGND VNB VPB VPWR Y
.ends

* Black-box entry subcircuit for sky130_fd_sc_hd__or4_2 abstract view
.subckt sky130_fd_sc_hd__or4_2 A B C D VGND VNB VPB VPWR X
.ends

* Black-box entry subcircuit for sky130_fd_sc_hd__o22a_1 abstract view
.subckt sky130_fd_sc_hd__o22a_1 A1 A2 B1 B2 VGND VNB VPB VPWR X
.ends

* Black-box entry subcircuit for sky130_fd_sc_hd__o41a_1 abstract view
.subckt sky130_fd_sc_hd__o41a_1 A1 A2 A3 A4 B1 VGND VNB VPB VPWR X
.ends

* Black-box entry subcircuit for sky130_fd_sc_hd__o221a_1 abstract view
.subckt sky130_fd_sc_hd__o221a_1 A1 A2 B1 B2 C1 VGND VNB VPB VPWR X
.ends

* Black-box entry subcircuit for sky130_fd_sc_hd__or3b_1 abstract view
.subckt sky130_fd_sc_hd__or3b_1 A B C_N VGND VNB VPB VPWR X
.ends

* Black-box entry subcircuit for sky130_fd_sc_hd__o2bb2a_1 abstract view
.subckt sky130_fd_sc_hd__o2bb2a_1 A1_N A2_N B1 B2 VGND VNB VPB VPWR X
.ends

* Black-box entry subcircuit for sky130_fd_sc_hd__nand3_1 abstract view
.subckt sky130_fd_sc_hd__nand3_1 A B C VGND VNB VPB VPWR Y
.ends

* Black-box entry subcircuit for sky130_fd_sc_hd__a21bo_1 abstract view
.subckt sky130_fd_sc_hd__a21bo_1 A1 A2 B1_N VGND VNB VPB VPWR X
.ends

* Black-box entry subcircuit for sky130_fd_sc_hd__nor3_2 abstract view
.subckt sky130_fd_sc_hd__nor3_2 A B C VGND VNB VPB VPWR Y
.ends

* Black-box entry subcircuit for sky130_fd_sc_hd__o31ai_1 abstract view
.subckt sky130_fd_sc_hd__o31ai_1 A1 A2 A3 B1 VGND VNB VPB VPWR Y
.ends

* Black-box entry subcircuit for sky130_fd_sc_hd__or2_2 abstract view
.subckt sky130_fd_sc_hd__or2_2 A B VGND VNB VPB VPWR X
.ends

.subckt pill_reminder VGND VPWR ack_btn buzzer clk interval_sel[0] interval_sel[1]
+ led missed_dose_flag rst_n tick_1min
XFILLER_0_13_73 VGND VGND VPWR VPWR sky130_fd_sc_hd__fill_1
XFILLER_0_18_29 VPWR VGND VPWR VGND sky130_ef_sc_hd__decap_12
X_131_ net8 state\[2\] VGND VGND VPWR VPWR _097_ sky130_fd_sc_hd__nor2_1
X_200_ _053_ _054_ _092_ VGND VGND VPWR VPWR _055_ sky130_fd_sc_hd__o21a_1
XFILLER_0_0_29 VPWR VGND VPWR VGND sky130_ef_sc_hd__decap_12
XFILLER_0_10_41 VPWR VGND VPWR VGND sky130_ef_sc_hd__decap_12
XFILLER_0_19_125 VGND VGND VPWR VPWR sky130_fd_sc_hd__decap_6
XTAP_TAPCELL_ROW_5_56 VGND VPWR sky130_fd_sc_hd__tapvpwrvgnd_1
XFILLER_0_21_62 VGND VGND VPWR VPWR sky130_fd_sc_hd__decap_4
XTAP_TAPCELL_ROW_20_87 VGND VPWR sky130_fd_sc_hd__tapvpwrvgnd_1
XTAP_TAPCELL_ROW_15_76 VGND VPWR sky130_fd_sc_hd__tapvpwrvgnd_1
Xoutput7 net7 VGND VGND VPWR VPWR led sky130_fd_sc_hd__clkbuf_2
XPHY_EDGE_ROW_21_Right_21 VGND VGND VPWR VPWR sky130_fd_sc_hd__decap_3
XFILLER_0_4_83 VGND VGND VPWR VPWR sky130_fd_sc_hd__fill_1
X_130_ ack_prev ack_s2 VGND VGND VPWR VPWR _096_ sky130_fd_sc_hd__or2b_1
XPHY_EDGE_ROW_12_Right_12 VGND VGND VPWR VPWR sky130_fd_sc_hd__decap_3
X_259_ clknet_1_0__leaf_clk _001_ VGND VGND VPWR VPWR net8 sky130_fd_sc_hd__dfxtp_1
XFILLER_0_10_53 VPWR VGND VPWR VGND sky130_ef_sc_hd__decap_12
XTAP_TAPCELL_ROW_5_57 VGND VPWR sky130_fd_sc_hd__tapvpwrvgnd_1
XFILLER_0_21_85 VPWR VGND VPWR VGND sky130_ef_sc_hd__decap_12
XFILLER_0_21_41 VPWR VGND VPWR VGND sky130_ef_sc_hd__decap_12
XFILLER_0_16_85 VPWR VGND VPWR VGND sky130_ef_sc_hd__decap_12
XFILLER_0_6_29 VGND VGND VPWR VPWR sky130_fd_sc_hd__decap_8
XPHY_EDGE_ROW_16_Left_38 VGND VGND VPWR VPWR sky130_fd_sc_hd__decap_3
XFILLER_0_16_52 VPWR VGND VPWR VGND sky130_ef_sc_hd__decap_12
XPHY_EDGE_ROW_6_Right_6 VGND VGND VPWR VPWR sky130_fd_sc_hd__decap_3
XTAP_TAPCELL_ROW_15_77 VGND VPWR sky130_fd_sc_hd__tapvpwrvgnd_1
Xoutput8 net8 VGND VGND VPWR VPWR missed_dose_flag sky130_fd_sc_hd__clkbuf_2
XFILLER_0_7_94 VGND VGND VPWR VPWR sky130_fd_sc_hd__decap_8
XFILLER_0_13_31 VGND VGND VPWR VPWR sky130_fd_sc_hd__fill_1
XPHY_EDGE_ROW_19_Left_41 VGND VGND VPWR VPWR sky130_fd_sc_hd__decap_3
XPHY_EDGE_ROW_4_Left_26 VGND VGND VPWR VPWR sky130_fd_sc_hd__decap_3
XFILLER_0_19_63 VGND VGND VPWR VPWR sky130_fd_sc_hd__decap_4
XFILLER_0_19_52 VGND VGND VPWR VPWR sky130_fd_sc_hd__decap_4
X_258_ clknet_1_0__leaf_clk _000_ VGND VGND VPWR VPWR state\[0\] sky130_fd_sc_hd__dfxtp_1
XFILLER_0_10_65 VGND VGND VPWR VPWR sky130_fd_sc_hd__decap_8
X_189_ _092_ _037_ VGND VGND VPWR VPWR _046_ sky130_fd_sc_hd__nor2_1
XFILLER_0_21_97 VPWR VGND VPWR VGND sky130_ef_sc_hd__decap_12
XFILLER_0_21_53 VGND VGND VPWR VPWR sky130_fd_sc_hd__decap_3
XFILLER_0_1_52 VGND VGND VPWR VPWR sky130_fd_sc_hd__decap_4
XFILLER_0_1_30 VGND VGND VPWR VPWR sky130_fd_sc_hd__decap_3
XFILLER_0_16_97 VGND VGND VPWR VPWR sky130_fd_sc_hd__decap_8
XFILLER_0_16_64 VGND VGND VPWR VPWR sky130_fd_sc_hd__fill_1
XFILLER_0_9_3 VGND VGND VPWR VPWR sky130_fd_sc_hd__fill_2
XFILLER_0_5_108 VGND VGND VPWR VPWR sky130_fd_sc_hd__decap_4
XPHY_EDGE_ROW_20_Left_42 VGND VGND VPWR VPWR sky130_fd_sc_hd__decap_3
XFILLER_0_4_41 VGND VGND VPWR VPWR sky130_fd_sc_hd__decap_6
XFILLER_0_4_74 VGND VGND VPWR VPWR sky130_fd_sc_hd__fill_2
XFILLER_0_4_85 VPWR VGND VPWR VGND sky130_ef_sc_hd__decap_12
X_188_ interval_cnt\[4\] _026_ interval_cnt\[5\] VGND VGND VPWR VPWR _045_ sky130_fd_sc_hd__o21ai_1
X_257_ clknet_1_1__leaf_clk _012_ VGND VGND VPWR VPWR interval_cnt\[9\] sky130_fd_sc_hd__dfxtp_1
XFILLER_0_8_128 VGND VGND VPWR VPWR sky130_fd_sc_hd__decap_3
XFILLER_0_16_43 VGND VGND VPWR VPWR sky130_fd_sc_hd__fill_2
XFILLER_0_4_97 VGND VGND VPWR VPWR sky130_fd_sc_hd__fill_1
XFILLER_0_10_89 VPWR VGND VPWR VGND sky130_ef_sc_hd__decap_12
X_256_ clknet_1_1__leaf_clk _011_ VGND VGND VPWR VPWR interval_cnt\[8\] sky130_fd_sc_hd__dfxtp_1
X_187_ _098_ _037_ _030_ VGND VGND VPWR VPWR _044_ sky130_fd_sc_hd__o21a_1
Xclkload0 clknet_1_1__leaf_clk VGND VGND VPWR VPWR clkload0/Y sky130_fd_sc_hd__clkinvlp_4
X_239_ blink_div\[0\] blink_div\[1\] _083_ VGND VGND VPWR VPWR _021_ sky130_fd_sc_hd__a21oi_1
XFILLER_0_21_113 VPWR VGND VPWR VGND sky130_ef_sc_hd__decap_12
XFILLER_0_16_11 VGND VGND VPWR VPWR sky130_fd_sc_hd__fill_2
XTAP_TAPCELL_ROW_21_90 VGND VPWR sky130_fd_sc_hd__tapvpwrvgnd_1
XPHY_EDGE_ROW_19_Right_19 VGND VGND VPWR VPWR sky130_fd_sc_hd__decap_3
XFILLER_0_1_113 VPWR VGND VPWR VGND sky130_ef_sc_hd__decap_12
XFILLER_0_13_67 VGND VGND VPWR VPWR sky130_fd_sc_hd__decap_6
X_272_ clknet_1_0__leaf_clk _024_ VGND VGND VPWR VPWR ack_s2 sky130_fd_sc_hd__dfxtp_1
XFILLER_0_4_54 VPWR VGND VPWR VGND sky130_ef_sc_hd__decap_12
X_255_ clknet_1_1__leaf_clk _010_ VGND VGND VPWR VPWR interval_cnt\[7\] sky130_fd_sc_hd__dfxtp_1
X_186_ interval_cnt\[4\] _114_ _039_ _043_ VGND VGND VPWR VPWR _008_ sky130_fd_sc_hd__a22o_1
XFILLER_0_19_99 VPWR VGND VPWR VGND sky130_ef_sc_hd__decap_12
X_169_ interval_cnt\[6\] _027_ _119_ VGND VGND VPWR VPWR _029_ sky130_fd_sc_hd__o21ai_1
X_238_ blink_div\[0\] blink_div\[1\] _107_ VGND VGND VPWR VPWR _083_ sky130_fd_sc_hd__o21ai_1
XFILLER_0_1_22 VGND VGND VPWR VPWR sky130_fd_sc_hd__decap_8
XFILLER_0_15_111 VGND VGND VPWR VPWR sky130_fd_sc_hd__fill_1
XFILLER_0_21_125 VGND VGND VPWR VPWR sky130_fd_sc_hd__decap_6
XFILLER_0_18_3 VPWR VGND VPWR VGND sky130_ef_sc_hd__decap_12
XTAP_TAPCELL_ROW_21_91 VGND VPWR sky130_fd_sc_hd__tapvpwrvgnd_1
XFILLER_0_1_125 VGND VGND VPWR VPWR sky130_fd_sc_hd__decap_6
X_271_ clknet_1_0__leaf_clk _023_ VGND VGND VPWR VPWR ack_s1 sky130_fd_sc_hd__dfxtp_1
XFILLER_0_4_66 VGND VGND VPWR VPWR sky130_fd_sc_hd__decap_8
X_254_ clknet_1_1__leaf_clk _009_ VGND VGND VPWR VPWR interval_cnt\[5\] sky130_fd_sc_hd__dfxtp_1
X_185_ _040_ _042_ _107_ VGND VGND VPWR VPWR _043_ sky130_fd_sc_hd__o21ai_1
XFILLER_0_21_57 VGND VGND VPWR VPWR sky130_fd_sc_hd__fill_2
X_168_ _114_ _027_ VGND VGND VPWR VPWR _028_ sky130_fd_sc_hd__or2_1
X_237_ _082_ VGND VGND VPWR VPWR _020_ sky130_fd_sc_hd__clkbuf_1
XPHY_EDGE_ROW_11_Left_33 VGND VGND VPWR VPWR sky130_fd_sc_hd__decap_3
XPHY_EDGE_ROW_1_Right_1 VGND VGND VPWR VPWR sky130_fd_sc_hd__decap_3
XFILLER_0_7_120 VGND VGND VPWR VPWR sky130_fd_sc_hd__decap_8
XFILLER_0_7_55 VGND VGND VPWR VPWR sky130_fd_sc_hd__fill_1
X_270_ clknet_1_0__leaf_clk _022_ VGND VGND VPWR VPWR blink_div\[2\] sky130_fd_sc_hd__dfxtp_1
XFILLER_0_19_35 VGND VGND VPWR VPWR sky130_fd_sc_hd__fill_1
X_253_ clknet_1_1__leaf_clk _008_ VGND VGND VPWR VPWR interval_cnt\[4\] sky130_fd_sc_hd__dfxtp_1
XFILLER_0_10_15 VPWR VGND VPWR VGND sky130_ef_sc_hd__decap_12
X_184_ interval_cnt\[4\] _026_ _041_ VGND VGND VPWR VPWR _042_ sky130_fd_sc_hd__a21oi_1
XFILLER_0_21_69 VPWR VGND VPWR VGND sky130_ef_sc_hd__decap_12
X_167_ interval_cnt\[5\] interval_cnt\[4\] _026_ VGND VGND VPWR VPWR _027_ sky130_fd_sc_hd__or3_1
X_236_ blink_div\[0\] _098_ VGND VGND VPWR VPWR _082_ sky130_fd_sc_hd__and2b_1
XFILLER_0_1_57 VPWR VGND VPWR VGND sky130_ef_sc_hd__decap_12
XFILLER_0_15_113 VPWR VGND VPWR VGND sky130_ef_sc_hd__decap_12
X_219_ window_cnt\[0\] _069_ window_cnt\[1\] VGND VGND VPWR VPWR _070_ sky130_fd_sc_hd__o21ai_1
XFILLER_0_12_105 VPWR VGND VPWR VGND sky130_ef_sc_hd__decap_12
Xclkbuf_0_clk clk VGND VGND VPWR VPWR clknet_0_clk sky130_fd_sc_hd__clkbuf_16
XFILLER_0_7_67 VGND VGND VPWR VPWR sky130_fd_sc_hd__fill_2
XPHY_EDGE_ROW_15_Right_15 VGND VGND VPWR VPWR sky130_fd_sc_hd__decap_3
XTAP_TAPCELL_ROW_3_52 VGND VPWR sky130_fd_sc_hd__tapvpwrvgnd_1
XTAP_TAPCELL_ROW_13_72 VGND VPWR sky130_fd_sc_hd__tapvpwrvgnd_1
X_252_ clknet_1_1__leaf_clk _007_ VGND VGND VPWR VPWR interval_cnt\[3\] sky130_fd_sc_hd__dfxtp_1
XFILLER_0_10_27 VGND VGND VPWR VPWR sky130_fd_sc_hd__fill_1
X_183_ interval_cnt\[4\] _026_ _092_ VGND VGND VPWR VPWR _041_ sky130_fd_sc_hd__o21ai_1
XFILLER_0_21_15 VPWR VGND VPWR VGND sky130_ef_sc_hd__decap_12
X_235_ window_cnt\[5\] _079_ _081_ _067_ VGND VGND VPWR VPWR _019_ sky130_fd_sc_hd__a211oi_1
XFILLER_0_1_69 VGND VGND VPWR VPWR sky130_fd_sc_hd__fill_1
X_166_ _025_ VGND VGND VPWR VPWR _026_ sky130_fd_sc_hd__clkbuf_2
XFILLER_0_15_125 VGND VGND VPWR VPWR sky130_fd_sc_hd__decap_6
X_149_ _108_ blink_div\[2\] VGND VGND VPWR VPWR _111_ sky130_fd_sc_hd__and2_1
X_218_ _063_ _064_ net5 _094_ VGND VGND VPWR VPWR _069_ sky130_fd_sc_hd__o211ai_4
XFILLER_0_12_117 VPWR VGND VPWR VGND sky130_ef_sc_hd__decap_12
XFILLER_0_16_37 VGND VGND VPWR VPWR sky130_fd_sc_hd__decap_3
XFILLER_0_4_125 VGND VGND VPWR VPWR sky130_fd_sc_hd__decap_6
XFILLER_0_7_35 VGND VGND VPWR VPWR sky130_fd_sc_hd__decap_4
XFILLER_0_16_3 VGND VGND VPWR VPWR sky130_fd_sc_hd__decap_8
XFILLER_0_7_6 VGND VGND VPWR VPWR sky130_fd_sc_hd__fill_1
XTAP_TAPCELL_ROW_3_53 VGND VPWR sky130_fd_sc_hd__tapvpwrvgnd_1
XFILLER_0_5_3 VPWR VGND VPWR VGND sky130_ef_sc_hd__decap_12
XFILLER_0_4_47 VGND VGND VPWR VPWR sky130_fd_sc_hd__fill_1
XTAP_TAPCELL_ROW_13_73 VGND VPWR sky130_fd_sc_hd__tapvpwrvgnd_1
X_251_ clknet_1_1__leaf_clk _006_ VGND VGND VPWR VPWR interval_cnt\[6\] sky130_fd_sc_hd__dfxtp_1
XFILLER_0_19_15 VPWR VGND VPWR VGND sky130_ef_sc_hd__decap_12
X_182_ _092_ _038_ VGND VGND VPWR VPWR _040_ sky130_fd_sc_hd__nor2_1
XFILLER_0_18_101 VPWR VGND VPWR VGND sky130_ef_sc_hd__decap_12
XFILLER_0_21_27 VGND VGND VPWR VPWR sky130_fd_sc_hd__fill_1
X_234_ _108_ _065_ _080_ window_cnt\[5\] VGND VGND VPWR VPWR _081_ sky130_fd_sc_hd__a31oi_1
XFILLER_0_1_15 VGND VGND VPWR VPWR sky130_fd_sc_hd__decap_4
X_165_ interval_cnt\[0\] interval_cnt\[1\] interval_cnt\[3\] interval_cnt\[2\] VGND
+ VGND VPWR VPWR _025_ sky130_fd_sc_hd__or4_1
X_148_ net8 blink_div\[2\] _108_ VGND VGND VPWR VPWR net7 sky130_fd_sc_hd__a21o_1
X_217_ _101_ _066_ _068_ VGND VGND VPWR VPWR _014_ sky130_fd_sc_hd__a21oi_1
XFILLER_0_12_129 VGND VGND VPWR VPWR sky130_fd_sc_hd__fill_2
XPHY_EDGE_ROW_15_Left_37 VGND VGND VPWR VPWR sky130_fd_sc_hd__decap_3
XFILLER_0_17_92 VGND VGND VPWR VPWR sky130_fd_sc_hd__decap_8
XPHY_EDGE_ROW_5_Right_5 VGND VGND VPWR VPWR sky130_fd_sc_hd__decap_3
XFILLER_0_4_15 VPWR VGND VPWR VGND sky130_ef_sc_hd__decap_12
XFILLER_0_19_27 VGND VGND VPWR VPWR sky130_fd_sc_hd__decap_8
XPHY_EDGE_ROW_18_Left_40 VGND VGND VPWR VPWR sky130_fd_sc_hd__decap_3
X_250_ clknet_1_1__leaf_clk _005_ VGND VGND VPWR VPWR interval_cnt\[2\] sky130_fd_sc_hd__dfxtp_1
XTAP_TAPCELL_ROW_0_44 VGND VPWR sky130_fd_sc_hd__tapvpwrvgnd_1
XFILLER_0_10_29 VPWR VGND VPWR VGND sky130_ef_sc_hd__decap_12
X_181_ _098_ _038_ _030_ VGND VGND VPWR VPWR _039_ sky130_fd_sc_hd__o21a_1
XTAP_TAPCELL_ROW_9_64 VGND VPWR sky130_fd_sc_hd__tapvpwrvgnd_1
XFILLER_0_18_113 VPWR VGND VPWR VGND sky130_ef_sc_hd__decap_12
XPHY_EDGE_ROW_3_Left_25 VGND VGND VPWR VPWR sky130_fd_sc_hd__decap_3
X_164_ interval_cnt\[2\] _114_ _122_ _119_ VGND VGND VPWR VPWR _005_ sky130_fd_sc_hd__a22o_1
X_233_ _078_ VGND VGND VPWR VPWR _080_ sky130_fd_sc_hd__inv_2
XFILLER_0_15_105 VGND VGND VPWR VPWR sky130_fd_sc_hd__decap_3
XTAP_TAPCELL_ROW_19_84 VGND VPWR sky130_fd_sc_hd__tapvpwrvgnd_1
X_216_ window_cnt\[0\] _065_ _067_ VGND VGND VPWR VPWR _068_ sky130_fd_sc_hd__a21o_1
XFILLER_0_7_102 VGND VGND VPWR VPWR sky130_fd_sc_hd__fill_1
X_147_ _107_ _108_ _096_ _105_ _110_ VGND VGND VPWR VPWR _002_ sky130_fd_sc_hd__a41o_1
XFILLER_0_2_92 VGND VGND VPWR VPWR sky130_fd_sc_hd__decap_6
XPHY_EDGE_ROW_20_Right_20 VGND VGND VPWR VPWR sky130_fd_sc_hd__decap_3
XPHY_EDGE_ROW_11_Right_11 VGND VGND VPWR VPWR sky130_fd_sc_hd__decap_3
XFILLER_0_21_3 VPWR VGND VPWR VGND sky130_ef_sc_hd__decap_12
XFILLER_0_4_27 VGND VGND VPWR VPWR sky130_fd_sc_hd__fill_1
XFILLER_0_14_83 VGND VGND VPWR VPWR sky130_fd_sc_hd__fill_1
X_180_ _036_ _037_ VGND VGND VPWR VPWR _038_ sky130_fd_sc_hd__nand2_1
XTAP_TAPCELL_ROW_0_45 VGND VPWR sky130_fd_sc_hd__tapvpwrvgnd_1
XTAP_TAPCELL_ROW_9_65 VGND VPWR sky130_fd_sc_hd__tapvpwrvgnd_1
XFILLER_0_18_125 VGND VGND VPWR VPWR sky130_fd_sc_hd__decap_6
XFILLER_0_21_29 VPWR VGND VPWR VGND sky130_ef_sc_hd__decap_12
X_163_ _120_ _121_ _114_ VGND VGND VPWR VPWR _122_ sky130_fd_sc_hd__a21oi_1
X_232_ _077_ _079_ _107_ VGND VGND VPWR VPWR _018_ sky130_fd_sc_hd__o21a_1
XFILLER_0_11_51 VGND VGND VPWR VPWR sky130_fd_sc_hd__decap_4
XFILLER_0_21_109 VGND VGND VPWR VPWR sky130_fd_sc_hd__decap_3
XTAP_TAPCELL_ROW_19_85 VGND VPWR sky130_fd_sc_hd__tapvpwrvgnd_1
XFILLER_0_16_29 VGND VGND VPWR VPWR sky130_fd_sc_hd__decap_8
X_215_ _098_ VGND VGND VPWR VPWR _067_ sky130_fd_sc_hd__inv_2
X_146_ _089_ _090_ _091_ _109_ VGND VGND VPWR VPWR _110_ sky130_fd_sc_hd__and4_1
XFILLER_0_17_83 VGND VGND VPWR VPWR sky130_fd_sc_hd__decap_4
X_129_ net4 _092_ VGND VGND VPWR VPWR _095_ sky130_fd_sc_hd__nand2_1
XFILLER_0_14_3 VPWR VGND VPWR VGND sky130_ef_sc_hd__decap_12
XFILLER_0_14_51 VGND VGND VPWR VPWR sky130_fd_sc_hd__fill_1
XFILLER_0_14_73 VGND VGND VPWR VPWR sky130_fd_sc_hd__fill_1
XFILLER_0_3_3 VPWR VGND VPWR VGND sky130_ef_sc_hd__decap_12
XTAP_TAPCELL_ROW_0_46 VGND VPWR sky130_fd_sc_hd__tapvpwrvgnd_1
X_162_ interval_cnt\[2\] _116_ VGND VGND VPWR VPWR _121_ sky130_fd_sc_hd__nand2_1
X_231_ _108_ _078_ _069_ VGND VGND VPWR VPWR _079_ sky130_fd_sc_hd__a21oi_1
Xinput1 ack_btn VGND VGND VPWR VPWR net1 sky130_fd_sc_hd__clkbuf_1
XTAP_TAPCELL_ROW_10_66 VGND VPWR sky130_fd_sc_hd__tapvpwrvgnd_1
XFILLER_0_20_121 VGND VGND VPWR VPWR sky130_fd_sc_hd__decap_8
X_214_ _108_ _065_ VGND VGND VPWR VPWR _066_ sky130_fd_sc_hd__nand2_1
X_145_ net4 net5 state\[0\] VGND VGND VPWR VPWR _109_ sky130_fd_sc_hd__and3_1
XFILLER_0_2_83 VGND VGND VPWR VPWR sky130_fd_sc_hd__fill_1
X_128_ _089_ _090_ _091_ _093_ VGND VGND VPWR VPWR _094_ sky130_fd_sc_hd__a31o_1
XPHY_EDGE_ROW_9_Right_9 VGND VGND VPWR VPWR sky130_fd_sc_hd__decap_3
XFILLER_0_4_29 VPWR VGND VPWR VGND sky130_ef_sc_hd__decap_12
XFILLER_0_14_85 VGND VGND VPWR VPWR sky130_fd_sc_hd__decap_4
XTAP_TAPCELL_ROW_0_47 VGND VPWR sky130_fd_sc_hd__tapvpwrvgnd_1
X_161_ interval_cnt\[2\] _116_ VGND VGND VPWR VPWR _120_ sky130_fd_sc_hd__or2_1
X_230_ _103_ _071_ VGND VGND VPWR VPWR _078_ sky130_fd_sc_hd__or2_1
Xinput2 interval_sel[0] VGND VGND VPWR VPWR net2 sky130_fd_sc_hd__buf_1
XPHY_EDGE_ROW_7_Left_29 VGND VGND VPWR VPWR sky130_fd_sc_hd__decap_3
XTAP_TAPCELL_ROW_10_67 VGND VPWR sky130_fd_sc_hd__tapvpwrvgnd_1
X_213_ _063_ _064_ net5 _094_ VGND VGND VPWR VPWR _065_ sky130_fd_sc_hd__o211a_1
X_144_ state\[2\] VGND VGND VPWR VPWR _108_ sky130_fd_sc_hd__buf_2
XTAP_TAPCELL_ROW_21_88 VGND VPWR sky130_fd_sc_hd__tapvpwrvgnd_1
XFILLER_0_11_100 VPWR VGND VPWR VGND sky130_ef_sc_hd__decap_12
XFILLER_0_17_74 VGND VGND VPWR VPWR sky130_fd_sc_hd__decap_6
XFILLER_0_17_30 VGND VGND VPWR VPWR sky130_fd_sc_hd__decap_8
X_127_ net5 _092_ VGND VGND VPWR VPWR _093_ sky130_fd_sc_hd__nand2_1
XFILLER_0_8_61 VGND VGND VPWR VPWR sky130_fd_sc_hd__fill_2
XFILLER_0_8_72 VGND VGND VPWR VPWR sky130_fd_sc_hd__decap_6
XFILLER_0_14_64 VGND VGND VPWR VPWR sky130_fd_sc_hd__fill_2
XFILLER_0_5_84 VPWR VGND VPWR VGND sky130_ef_sc_hd__decap_12
X_160_ interval_cnt\[1\] _114_ _118_ _119_ VGND VGND VPWR VPWR _004_ sky130_fd_sc_hd__a22o_1
Xinput3 interval_sel[1] VGND VGND VPWR VPWR net3 sky130_fd_sc_hd__buf_1
XPHY_EDGE_ROW_18_Right_18 VGND VGND VPWR VPWR sky130_fd_sc_hd__decap_3
X_143_ _098_ VGND VGND VPWR VPWR _107_ sky130_fd_sc_hd__buf_2
XTAP_TAPCELL_ROW_6_58 VGND VPWR sky130_fd_sc_hd__tapvpwrvgnd_1
X_212_ _101_ _103_ _104_ _108_ _096_ VGND VGND VPWR VPWR _064_ sky130_fd_sc_hd__o311a_1
XFILLER_0_7_128 VGND VGND VPWR VPWR sky130_fd_sc_hd__decap_3
XTAP_TAPCELL_ROW_21_89 VGND VPWR sky130_fd_sc_hd__tapvpwrvgnd_1
XFILLER_0_2_85 VGND VGND VPWR VPWR sky130_fd_sc_hd__fill_2
X_126_ state\[0\] VGND VGND VPWR VPWR _092_ sky130_fd_sc_hd__buf_2
XPHY_EDGE_ROW_10_Left_32 VGND VGND VPWR VPWR sky130_fd_sc_hd__decap_3
XTAP_TAPCELL_ROW_16_78 VGND VPWR sky130_fd_sc_hd__tapvpwrvgnd_1
XPHY_EDGE_ROW_0_Right_0 VGND VGND VPWR VPWR sky130_fd_sc_hd__decap_3
XFILLER_0_12_3 VGND VGND VPWR VPWR sky130_fd_sc_hd__decap_3
XFILLER_0_5_63 VPWR VGND VPWR VGND sky130_ef_sc_hd__decap_12
XFILLER_0_5_96 VPWR VGND VPWR VGND sky130_ef_sc_hd__decap_12
XFILLER_0_1_3 VPWR VGND VPWR VGND sky130_ef_sc_hd__decap_12
Xinput4 rst_n VGND VGND VPWR VPWR net4 sky130_fd_sc_hd__buf_1
XFILLER_0_11_55 VGND VGND VPWR VPWR sky130_fd_sc_hd__fill_1
XFILLER_0_11_88 VPWR VGND VPWR VGND sky130_ef_sc_hd__decap_12
X_142_ _100_ _105_ _106_ VGND VGND VPWR VPWR _001_ sky130_fd_sc_hd__a21boi_1
XTAP_TAPCELL_ROW_6_59 VGND VPWR sky130_fd_sc_hd__tapvpwrvgnd_1
X_211_ _108_ _092_ VGND VGND VPWR VPWR _063_ sky130_fd_sc_hd__and2b_1
XFILLER_0_14_121 VGND VGND VPWR VPWR sky130_fd_sc_hd__decap_8
XFILLER_0_11_113 VPWR VGND VPWR VGND sky130_ef_sc_hd__decap_12
X_125_ interval_cnt\[3\] interval_cnt\[2\] interval_cnt\[9\] interval_cnt\[8\] VGND
+ VGND VPWR VPWR _091_ sky130_fd_sc_hd__nor4_1
XFILLER_0_17_87 VGND VGND VPWR VPWR sky130_fd_sc_hd__fill_1
XTAP_TAPCELL_ROW_16_79 VGND VPWR sky130_fd_sc_hd__tapvpwrvgnd_1
XFILLER_0_0_113 VPWR VGND VPWR VGND sky130_ef_sc_hd__decap_12
XFILLER_0_8_96 VGND VGND VPWR VPWR sky130_fd_sc_hd__fill_1
XFILLER_0_14_44 VGND VGND VPWR VPWR sky130_fd_sc_hd__fill_1
XFILLER_0_14_99 VGND VGND VPWR VPWR sky130_fd_sc_hd__decap_6
XFILLER_0_5_75 VGND VGND VPWR VPWR sky130_fd_sc_hd__decap_3
Xinput5 tick_1min VGND VGND VPWR VPWR net5 sky130_fd_sc_hd__buf_2
X_210_ _062_ VGND VGND VPWR VPWR _013_ sky130_fd_sc_hd__clkbuf_1
X_141_ _097_ net4 _096_ VGND VGND VPWR VPWR _106_ sky130_fd_sc_hd__and3b_1
XFILLER_0_2_65 VGND VGND VPWR VPWR sky130_fd_sc_hd__fill_2
XFILLER_0_11_125 VGND VGND VPWR VPWR sky130_fd_sc_hd__decap_6
X_124_ interval_cnt\[1\] interval_cnt\[0\] VGND VGND VPWR VPWR _090_ sky130_fd_sc_hd__and2b_1
XFILLER_0_17_55 VGND VGND VPWR VPWR sky130_fd_sc_hd__fill_1
XFILLER_0_17_11 VGND VGND VPWR VPWR sky130_fd_sc_hd__decap_3
XFILLER_0_3_111 VGND VGND VPWR VPWR sky130_fd_sc_hd__fill_1
XFILLER_0_0_125 VGND VGND VPWR VPWR sky130_fd_sc_hd__decap_6
XFILLER_0_11_57 VGND VGND VPWR VPWR sky130_fd_sc_hd__decap_3
X_140_ _101_ _102_ _103_ _104_ VGND VGND VPWR VPWR _105_ sky130_fd_sc_hd__or4_1
XPHY_EDGE_ROW_14_Right_14 VGND VGND VPWR VPWR sky130_fd_sc_hd__decap_3
XFILLER_0_2_11 VGND VGND VPWR VPWR sky130_fd_sc_hd__fill_1
X_269_ clknet_1_0__leaf_clk _021_ VGND VGND VPWR VPWR blink_div\[1\] sky130_fd_sc_hd__dfxtp_1
X_123_ interval_cnt\[5\] interval_cnt\[4\] interval_cnt\[6\] interval_cnt\[7\] VGND
+ VGND VPWR VPWR _089_ sky130_fd_sc_hd__nor4_1
XTAP_TAPCELL_ROW_7_60 VGND VPWR sky130_fd_sc_hd__tapvpwrvgnd_1
XPHY_EDGE_ROW_4_Right_4 VGND VGND VPWR VPWR sky130_fd_sc_hd__decap_3
XPHY_EDGE_ROW_14_Left_36 VGND VGND VPWR VPWR sky130_fd_sc_hd__decap_3
XTAP_TAPCELL_ROW_17_80 VGND VPWR sky130_fd_sc_hd__tapvpwrvgnd_1
XFILLER_0_14_79 VGND VGND VPWR VPWR sky130_fd_sc_hd__decap_4
XFILLER_0_5_55 VGND VGND VPWR VPWR sky130_fd_sc_hd__fill_1
XFILLER_0_10_3 VPWR VGND VPWR VGND sky130_ef_sc_hd__decap_12
XPHY_EDGE_ROW_2_Left_24 VGND VGND VPWR VPWR sky130_fd_sc_hd__decap_3
X_268_ clknet_1_0__leaf_clk _020_ VGND VGND VPWR VPWR blink_div\[0\] sky130_fd_sc_hd__dfxtp_1
X_199_ _050_ _026_ interval_cnt\[8\] VGND VGND VPWR VPWR _054_ sky130_fd_sc_hd__o21a_1
XFILLER_0_17_57 VGND VGND VPWR VPWR sky130_fd_sc_hd__fill_1
XTAP_TAPCELL_ROW_7_61 VGND VPWR sky130_fd_sc_hd__tapvpwrvgnd_1
XFILLER_0_3_113 VPWR VGND VPWR VGND sky130_ef_sc_hd__decap_12
XFILLER_0_3_102 VGND VGND VPWR VPWR sky130_fd_sc_hd__fill_2
XFILLER_0_8_88 VGND VGND VPWR VPWR sky130_fd_sc_hd__decap_8
XTAP_TAPCELL_ROW_17_81 VGND VPWR sky130_fd_sc_hd__tapvpwrvgnd_1
XFILLER_0_14_58 VGND VGND VPWR VPWR sky130_fd_sc_hd__fill_1
XFILLER_0_17_100 VGND VGND VPWR VPWR sky130_fd_sc_hd__fill_1
XFILLER_0_11_15 VPWR VGND VPWR VGND sky130_ef_sc_hd__decap_12
X_267_ clknet_1_0__leaf_clk _019_ VGND VGND VPWR VPWR window_cnt\[5\] sky130_fd_sc_hd__dfxtp_1
X_198_ interval_cnt\[8\] _050_ _026_ VGND VGND VPWR VPWR _053_ sky130_fd_sc_hd__nor3_1
XFILLER_0_17_69 VGND VGND VPWR VPWR sky130_fd_sc_hd__fill_1
XFILLER_0_17_47 VGND VGND VPWR VPWR sky130_fd_sc_hd__decap_3
XFILLER_0_3_125 VGND VGND VPWR VPWR sky130_fd_sc_hd__decap_6
Xclkbuf_1_0__f_clk clknet_0_clk VGND VGND VPWR VPWR clknet_1_0__leaf_clk sky130_fd_sc_hd__clkbuf_16
XFILLER_0_8_34 VPWR VGND VPWR VGND sky130_ef_sc_hd__decap_12
XFILLER_0_14_15 VGND VGND VPWR VPWR sky130_fd_sc_hd__decap_3
XFILLER_0_14_37 VGND VGND VPWR VPWR sky130_fd_sc_hd__fill_1
XFILLER_0_11_27 VPWR VGND VPWR VGND sky130_ef_sc_hd__decap_12
XFILLER_0_20_129 VGND VGND VPWR VPWR sky130_fd_sc_hd__fill_2
X_197_ interval_cnt\[7\] _114_ _052_ VGND VGND VPWR VPWR _010_ sky130_fd_sc_hd__a21o_1
X_266_ clknet_1_0__leaf_clk _018_ VGND VGND VPWR VPWR window_cnt\[4\] sky130_fd_sc_hd__dfxtp_1
XPHY_EDGE_ROW_10_Right_10 VGND VGND VPWR VPWR sky130_fd_sc_hd__decap_3
XFILLER_0_12_92 VGND VGND VPWR VPWR sky130_fd_sc_hd__decap_4
X_249_ clknet_1_1__leaf_clk _004_ VGND VGND VPWR VPWR interval_cnt\[1\] sky130_fd_sc_hd__dfxtp_1
XFILLER_0_8_46 VGND VGND VPWR VPWR sky130_fd_sc_hd__decap_3
XFILLER_0_14_27 VGND VGND VPWR VPWR sky130_fd_sc_hd__fill_1
XPHY_EDGE_ROW_8_Right_8 VGND VGND VPWR VPWR sky130_fd_sc_hd__decap_3
XFILLER_0_5_25 VPWR VGND VPWR VGND sky130_ef_sc_hd__decap_12
XFILLER_0_11_39 VPWR VGND VPWR VGND sky130_ef_sc_hd__decap_12
X_196_ _095_ _049_ _051_ _030_ _031_ VGND VGND VPWR VPWR _052_ sky130_fd_sc_hd__o311a_1
X_265_ clknet_1_0__leaf_clk _017_ VGND VGND VPWR VPWR window_cnt\[3\] sky130_fd_sc_hd__dfxtp_1
XPHY_EDGE_ROW_6_Left_28 VGND VGND VPWR VPWR sky130_fd_sc_hd__decap_3
XFILLER_0_17_38 VGND VGND VPWR VPWR sky130_fd_sc_hd__fill_2
X_179_ net2 net3 VGND VGND VPWR VPWR _037_ sky130_fd_sc_hd__nand2_1
X_248_ clknet_1_1__leaf_clk _003_ VGND VGND VPWR VPWR interval_cnt\[0\] sky130_fd_sc_hd__dfxtp_1
XFILLER_0_19_3 VPWR VGND VPWR VGND sky130_ef_sc_hd__decap_12
XPHY_EDGE_ROW_9_Left_31 VGND VGND VPWR VPWR sky130_fd_sc_hd__decap_3
XTAP_TAPCELL_ROW_4_54 VGND VPWR sky130_fd_sc_hd__tapvpwrvgnd_1
XFILLER_0_20_82 VGND VGND VPWR VPWR sky130_fd_sc_hd__fill_2
XFILLER_0_8_3 VGND VGND VPWR VPWR sky130_fd_sc_hd__fill_1
XFILLER_0_9_90 VPWR VGND VPWR VGND sky130_ef_sc_hd__decap_12
XFILLER_0_5_15 VGND VGND VPWR VPWR sky130_fd_sc_hd__decap_6
XFILLER_0_5_37 VPWR VGND VPWR VGND sky130_ef_sc_hd__decap_12
XTAP_TAPCELL_ROW_14_74 VGND VPWR sky130_fd_sc_hd__tapvpwrvgnd_1
XFILLER_0_20_109 VPWR VGND VPWR VGND sky130_ef_sc_hd__decap_12
X_195_ _050_ _026_ VGND VGND VPWR VPWR _051_ sky130_fd_sc_hd__nor2_1
X_264_ clknet_1_0__leaf_clk _016_ VGND VGND VPWR VPWR window_cnt\[2\] sky130_fd_sc_hd__dfxtp_1
XFILLER_0_6_125 VGND VGND VPWR VPWR sky130_fd_sc_hd__decap_6
X_247_ _088_ VGND VGND VPWR VPWR _024_ sky130_fd_sc_hd__clkbuf_1
X_178_ net2 net3 VGND VGND VPWR VPWR _036_ sky130_fd_sc_hd__or2_1
XFILLER_0_0_109 VGND VGND VPWR VPWR sky130_fd_sc_hd__decap_3
XTAP_TAPCELL_ROW_4_55 VGND VPWR sky130_fd_sc_hd__tapvpwrvgnd_1
XFILLER_0_14_29 VGND VGND VPWR VPWR sky130_fd_sc_hd__decap_8
XFILLER_0_5_49 VGND VGND VPWR VPWR sky130_fd_sc_hd__decap_3
XTAP_TAPCELL_ROW_14_75 VGND VPWR sky130_fd_sc_hd__tapvpwrvgnd_1
XFILLER_0_14_129 VGND VGND VPWR VPWR sky130_fd_sc_hd__fill_2
X_194_ interval_cnt\[5\] interval_cnt\[4\] interval_cnt\[6\] interval_cnt\[7\] VGND
+ VGND VPWR VPWR _050_ sky130_fd_sc_hd__or4_2
X_263_ clknet_1_0__leaf_clk _015_ VGND VGND VPWR VPWR window_cnt\[1\] sky130_fd_sc_hd__dfxtp_1
XFILLER_0_10_121 VGND VGND VPWR VPWR sky130_fd_sc_hd__decap_3
X_177_ interval_cnt\[3\] _032_ _034_ _035_ VGND VGND VPWR VPWR _007_ sky130_fd_sc_hd__o22a_1
X_246_ _098_ ack_s1 VGND VGND VPWR VPWR _088_ sky130_fd_sc_hd__and2_1
X_229_ window_cnt\[3\] window_cnt\[2\] _069_ _071_ window_cnt\[4\] VGND VGND VPWR
+ VPWR _077_ sky130_fd_sc_hd__o41a_1
XFILLER_0_20_62 VPWR VGND VPWR VGND sky130_ef_sc_hd__decap_12
XPHY_EDGE_ROW_17_Right_17 VGND VGND VPWR VPWR sky130_fd_sc_hd__decap_3
XFILLER_0_0_83 VGND VGND VPWR VPWR sky130_fd_sc_hd__fill_1
XFILLER_0_9_102 VGND VGND VPWR VPWR sky130_fd_sc_hd__decap_4
X_193_ interval_cnt\[6\] _027_ interval_cnt\[7\] VGND VGND VPWR VPWR _049_ sky130_fd_sc_hd__o21a_1
X_262_ clknet_1_0__leaf_clk _014_ VGND VGND VPWR VPWR window_cnt\[0\] sky130_fd_sc_hd__dfxtp_1
XFILLER_0_12_52 VPWR VGND VPWR VGND sky130_ef_sc_hd__decap_12
XFILLER_0_12_96 VGND VGND VPWR VPWR sky130_fd_sc_hd__fill_1
X_176_ _030_ _031_ VGND VGND VPWR VPWR _035_ sky130_fd_sc_hd__nand2_1
X_245_ _087_ VGND VGND VPWR VPWR _023_ sky130_fd_sc_hd__clkbuf_1
X_228_ window_cnt\[3\] _074_ _076_ _066_ _107_ VGND VGND VPWR VPWR _017_ sky130_fd_sc_hd__o221a_1
X_159_ _098_ _092_ VGND VGND VPWR VPWR _119_ sky130_fd_sc_hd__and2_1
XFILLER_0_20_85 VPWR VGND VPWR VGND sky130_ef_sc_hd__decap_12
XFILLER_0_20_74 VGND VGND VPWR VPWR sky130_fd_sc_hd__decap_8
XFILLER_0_20_41 VGND VGND VPWR VPWR sky130_fd_sc_hd__decap_4
XFILLER_0_17_3 VGND VGND VPWR VPWR sky130_fd_sc_hd__decap_8
XFILLER_0_15_85 VPWR VGND VPWR VGND sky130_ef_sc_hd__decap_12
XFILLER_0_6_3 VGND VGND VPWR VPWR sky130_fd_sc_hd__decap_8
X_192_ interval_cnt\[5\] _114_ _044_ _048_ VGND VGND VPWR VPWR _009_ sky130_fd_sc_hd__a22o_1
XFILLER_0_6_83 VGND VGND VPWR VPWR sky130_fd_sc_hd__fill_1
X_261_ clknet_1_0__leaf_clk _013_ VGND VGND VPWR VPWR ack_prev sky130_fd_sc_hd__dfxtp_1
XFILLER_0_10_101 VPWR VGND VPWR VGND sky130_ef_sc_hd__decap_12
XFILLER_0_12_64 VGND VGND VPWR VPWR sky130_fd_sc_hd__decap_3
XFILLER_0_12_75 VGND VGND VPWR VPWR sky130_fd_sc_hd__fill_2
X_175_ _033_ _120_ _119_ VGND VGND VPWR VPWR _034_ sky130_fd_sc_hd__o21a_1
X_244_ _098_ net1 VGND VGND VPWR VPWR _087_ sky130_fd_sc_hd__and2_1
XFILLER_0_3_51 VGND VGND VPWR VPWR sky130_fd_sc_hd__decap_4
XFILLER_0_18_41 VGND VGND VPWR VPWR sky130_fd_sc_hd__fill_2
X_227_ window_cnt\[2\] _071_ window_cnt\[3\] VGND VGND VPWR VPWR _076_ sky130_fd_sc_hd__or3b_1
X_158_ _116_ _117_ _114_ VGND VGND VPWR VPWR _118_ sky130_fd_sc_hd__a21oi_1
XFILLER_0_20_97 VPWR VGND VPWR VGND sky130_ef_sc_hd__decap_12
XPHY_EDGE_ROW_3_Right_3 VGND VGND VPWR VPWR sky130_fd_sc_hd__decap_3
XFILLER_0_0_85 VPWR VGND VPWR VGND sky130_ef_sc_hd__decap_12
XFILLER_0_0_63 VPWR VGND VPWR VGND sky130_ef_sc_hd__decap_12
XFILLER_0_0_41 VGND VGND VPWR VPWR sky130_fd_sc_hd__decap_4
XPHY_EDGE_ROW_13_Left_35 VGND VGND VPWR VPWR sky130_fd_sc_hd__decap_3
Xclkbuf_1_1__f_clk clknet_0_clk VGND VGND VPWR VPWR clknet_1_1__leaf_clk sky130_fd_sc_hd__clkbuf_16
XFILLER_0_17_129 VGND VGND VPWR VPWR sky130_fd_sc_hd__fill_2
XFILLER_0_15_20 VPWR VGND VPWR VGND sky130_ef_sc_hd__decap_12
XFILLER_0_15_97 VGND VGND VPWR VPWR sky130_fd_sc_hd__decap_8
XTAP_TAPCELL_ROW_1_48 VGND VPWR sky130_fd_sc_hd__tapvpwrvgnd_1
X_260_ clknet_1_0__leaf_clk _002_ VGND VGND VPWR VPWR state\[2\] sky130_fd_sc_hd__dfxtp_1
X_191_ _107_ _047_ VGND VGND VPWR VPWR _048_ sky130_fd_sc_hd__nand2_1
XFILLER_0_10_113 VGND VGND VPWR VPWR sky130_fd_sc_hd__decap_8
XTAP_TAPCELL_ROW_11_68 VGND VPWR sky130_fd_sc_hd__tapvpwrvgnd_1
X_174_ interval_cnt\[3\] VGND VGND VPWR VPWR _033_ sky130_fd_sc_hd__inv_2
X_243_ _086_ VGND VGND VPWR VPWR _022_ sky130_fd_sc_hd__clkbuf_1
XPHY_EDGE_ROW_1_Left_23 VGND VGND VPWR VPWR sky130_fd_sc_hd__decap_3
X_226_ _074_ _075_ _107_ VGND VGND VPWR VPWR _016_ sky130_fd_sc_hd__o21a_1
X_157_ interval_cnt\[0\] interval_cnt\[1\] VGND VGND VPWR VPWR _117_ sky130_fd_sc_hd__nand2_1
XFILLER_0_0_97 VPWR VGND VPWR VGND sky130_ef_sc_hd__decap_12
XFILLER_0_0_75 VGND VGND VPWR VPWR sky130_fd_sc_hd__decap_8
X_209_ _107_ ack_s2 VGND VGND VPWR VPWR _062_ sky130_fd_sc_hd__and2_1
XPHY_EDGE_ROW_13_Right_13 VGND VGND VPWR VPWR sky130_fd_sc_hd__decap_3
XFILLER_0_15_32 VPWR VGND VPWR VGND sky130_ef_sc_hd__decap_12
XFILLER_0_16_130 VGND VGND VPWR VPWR sky130_fd_sc_hd__fill_1
XTAP_TAPCELL_ROW_1_49 VGND VPWR sky130_fd_sc_hd__tapvpwrvgnd_1
XFILLER_0_6_96 VPWR VGND VPWR VGND sky130_ef_sc_hd__decap_12
X_190_ _092_ _027_ _045_ _046_ VGND VGND VPWR VPWR _047_ sky130_fd_sc_hd__a31o_1
XFILLER_0_6_108 VGND VGND VPWR VPWR sky130_fd_sc_hd__decap_3
XTAP_TAPCELL_ROW_11_69 VGND VPWR sky130_fd_sc_hd__tapvpwrvgnd_1
X_173_ _120_ _031_ _114_ VGND VGND VPWR VPWR _032_ sky130_fd_sc_hd__a21oi_1
X_242_ _098_ _084_ _085_ VGND VGND VPWR VPWR _086_ sky130_fd_sc_hd__and3_1
X_225_ _069_ _071_ window_cnt\[2\] VGND VGND VPWR VPWR _075_ sky130_fd_sc_hd__o21a_1
X_156_ interval_cnt\[0\] interval_cnt\[1\] VGND VGND VPWR VPWR _116_ sky130_fd_sc_hd__or2_1
X_139_ window_cnt\[5\] window_cnt\[1\] VGND VGND VPWR VPWR _104_ sky130_fd_sc_hd__or2_1
X_208_ _044_ _061_ interval_cnt\[9\] _030_ VGND VGND VPWR VPWR _012_ sky130_fd_sc_hd__o2bb2a_1
XFILLER_0_9_63 VGND VGND VPWR VPWR sky130_fd_sc_hd__fill_1
XFILLER_0_15_44 VPWR VGND VPWR VGND sky130_ef_sc_hd__decap_12
XFILLER_0_15_3 VPWR VGND VPWR VGND sky130_ef_sc_hd__decap_12
XFILLER_0_4_3 VPWR VGND VPWR VGND sky130_ef_sc_hd__decap_12
X_241_ blink_div\[0\] blink_div\[2\] blink_div\[1\] VGND VGND VPWR VPWR _085_ sky130_fd_sc_hd__nand3_1
X_172_ net3 _119_ net2 VGND VGND VPWR VPWR _031_ sky130_fd_sc_hd__or3b_1
X_224_ _069_ _073_ VGND VGND VPWR VPWR _074_ sky130_fd_sc_hd__nor2_1
X_155_ interval_cnt\[0\] _114_ _115_ VGND VGND VPWR VPWR _003_ sky130_fd_sc_hd__a21bo_1
XFILLER_0_20_45 VGND VGND VPWR VPWR sky130_fd_sc_hd__fill_1
X_138_ window_cnt\[4\] window_cnt\[3\] window_cnt\[2\] VGND VGND VPWR VPWR _103_ sky130_fd_sc_hd__or3_1
X_207_ _107_ _060_ VGND VGND VPWR VPWR _061_ sky130_fd_sc_hd__nand2_1
XFILLER_0_9_53 VGND VGND VPWR VPWR sky130_fd_sc_hd__decap_3
XPHY_EDGE_ROW_17_Left_39 VGND VGND VPWR VPWR sky130_fd_sc_hd__decap_3
XPHY_EDGE_ROW_7_Right_7 VGND VGND VPWR VPWR sky130_fd_sc_hd__decap_3
XFILLER_0_9_129 VGND VGND VPWR VPWR sky130_fd_sc_hd__fill_2
XTAP_TAPCELL_ROW_2_50 VGND VPWR sky130_fd_sc_hd__tapvpwrvgnd_1
XFILLER_0_12_35 VGND VGND VPWR VPWR sky130_fd_sc_hd__fill_1
X_171_ interval_cnt\[6\] _028_ _029_ _030_ VGND VGND VPWR VPWR _006_ sky130_fd_sc_hd__a22o_1
X_240_ blink_div\[0\] blink_div\[1\] blink_div\[2\] VGND VGND VPWR VPWR _084_ sky130_fd_sc_hd__a21o_1
XFILLER_0_3_55 VGND VGND VPWR VPWR sky130_fd_sc_hd__fill_1
XFILLER_0_3_33 VGND VGND VPWR VPWR sky130_fd_sc_hd__fill_1
XPHY_EDGE_ROW_5_Left_27 VGND VGND VPWR VPWR sky130_fd_sc_hd__decap_3
X_223_ window_cnt\[2\] _071_ _108_ VGND VGND VPWR VPWR _073_ sky130_fd_sc_hd__o21a_1
XTAP_TAPCELL_ROW_12_70 VGND VPWR sky130_fd_sc_hd__tapvpwrvgnd_1
X_154_ interval_cnt\[0\] _095_ _113_ VGND VGND VPWR VPWR _115_ sky130_fd_sc_hd__or3_1
X_137_ net5 VGND VGND VPWR VPWR _102_ sky130_fd_sc_hd__inv_2
X_206_ _092_ _058_ _059_ _046_ VGND VGND VPWR VPWR _060_ sky130_fd_sc_hd__a31o_1
XFILLER_0_9_21 VPWR VGND VPWR VGND sky130_ef_sc_hd__decap_12
XPHY_EDGE_ROW_8_Left_30 VGND VGND VPWR VPWR sky130_fd_sc_hd__decap_3
XFILLER_0_15_57 VGND VGND VPWR VPWR sky130_fd_sc_hd__decap_8
XFILLER_0_20_3 VPWR VGND VPWR VGND sky130_ef_sc_hd__decap_12
XTAP_TAPCELL_ROW_2_51 VGND VPWR sky130_fd_sc_hd__tapvpwrvgnd_1
X_170_ _112_ _106_ _110_ VGND VGND VPWR VPWR _030_ sky130_fd_sc_hd__nor3_2
XPHY_EDGE_ROW_21_Left_43 VGND VGND VPWR VPWR sky130_fd_sc_hd__decap_3
XTAP_TAPCELL_ROW_12_71 VGND VPWR sky130_fd_sc_hd__tapvpwrvgnd_1
X_222_ _070_ _072_ _067_ VGND VGND VPWR VPWR _015_ sky130_fd_sc_hd__a21oi_1
X_153_ _113_ VGND VGND VPWR VPWR _114_ sky130_fd_sc_hd__buf_2
X_136_ window_cnt\[0\] VGND VGND VPWR VPWR _101_ sky130_fd_sc_hd__inv_2
X_205_ interval_cnt\[8\] _050_ _026_ _057_ VGND VGND VPWR VPWR _059_ sky130_fd_sc_hd__o31ai_1
XFILLER_0_0_57 VGND VGND VPWR VPWR sky130_fd_sc_hd__fill_2
XFILLER_0_9_33 VPWR VGND VPWR VGND sky130_ef_sc_hd__decap_12
XFILLER_0_6_56 VGND VGND VPWR VPWR sky130_fd_sc_hd__decap_3
XFILLER_0_13_3 VGND VGND VPWR VPWR sky130_fd_sc_hd__decap_4
XFILLER_0_12_26 VGND VGND VPWR VPWR sky130_fd_sc_hd__fill_2
XFILLER_0_2_3 VGND VGND VPWR VPWR sky130_fd_sc_hd__decap_8
XFILLER_0_2_104 VPWR VGND VPWR VGND sky130_ef_sc_hd__decap_12
XFILLER_0_3_57 VPWR VGND VPWR VGND sky130_ef_sc_hd__decap_12
XFILLER_0_18_69 VGND VGND VPWR VPWR sky130_fd_sc_hd__decap_3
XFILLER_0_18_47 VGND VGND VPWR VPWR sky130_fd_sc_hd__decap_4
X_221_ _108_ _071_ _069_ VGND VGND VPWR VPWR _072_ sky130_fd_sc_hd__a21o_1
XTAP_TAPCELL_ROW_8_62 VGND VPWR sky130_fd_sc_hd__tapvpwrvgnd_1
X_152_ _112_ _106_ _110_ VGND VGND VPWR VPWR _113_ sky130_fd_sc_hd__or3_1
X_204_ _057_ interval_cnt\[8\] _050_ _026_ VGND VGND VPWR VPWR _058_ sky130_fd_sc_hd__or4_1
XFILLER_0_20_15 VPWR VGND VPWR VGND sky130_ef_sc_hd__decap_12
X_135_ net8 VGND VGND VPWR VPWR _100_ sky130_fd_sc_hd__inv_2
XFILLER_0_9_45 VGND VGND VPWR VPWR sky130_fd_sc_hd__decap_8
XTAP_TAPCELL_ROW_18_82 VGND VPWR sky130_fd_sc_hd__tapvpwrvgnd_1
XFILLER_0_15_15 VGND VGND VPWR VPWR sky130_fd_sc_hd__fill_1
XFILLER_0_1_90 VGND VGND VPWR VPWR sky130_fd_sc_hd__decap_6
XFILLER_0_6_79 VGND VGND VPWR VPWR sky130_fd_sc_hd__decap_4
XFILLER_0_5_113 VPWR VGND VPWR VGND sky130_ef_sc_hd__decap_12
XFILLER_0_2_116 VPWR VGND VPWR VGND sky130_ef_sc_hd__decap_12
XFILLER_0_3_69 VGND VGND VPWR VPWR sky130_fd_sc_hd__decap_4
XFILLER_0_18_15 VPWR VGND VPWR VGND sky130_ef_sc_hd__decap_12
X_220_ window_cnt\[1\] window_cnt\[0\] VGND VGND VPWR VPWR _071_ sky130_fd_sc_hd__or2_2
X_151_ net5 _095_ VGND VGND VPWR VPWR _112_ sky130_fd_sc_hd__nor2_1
XTAP_TAPCELL_ROW_8_63 VGND VPWR sky130_fd_sc_hd__tapvpwrvgnd_1
XFILLER_0_20_27 VGND VGND VPWR VPWR sky130_fd_sc_hd__fill_1
XFILLER_0_0_15 VPWR VGND VPWR VGND sky130_ef_sc_hd__decap_12
X_134_ _094_ _099_ VGND VGND VPWR VPWR _000_ sky130_fd_sc_hd__nand2_1
X_203_ interval_cnt\[9\] VGND VGND VPWR VPWR _057_ sky130_fd_sc_hd__inv_2
XFILLER_0_19_111 VGND VGND VPWR VPWR sky130_fd_sc_hd__fill_1
XTAP_TAPCELL_ROW_18_83 VGND VPWR sky130_fd_sc_hd__tapvpwrvgnd_1
XFILLER_0_9_57 VGND VGND VPWR VPWR sky130_fd_sc_hd__decap_6
XFILLER_0_21_81 VGND VGND VPWR VPWR sky130_fd_sc_hd__decap_3
XFILLER_0_16_114 VPWR VGND VPWR VGND sky130_ef_sc_hd__decap_12
XFILLER_0_5_125 VGND VGND VPWR VPWR sky130_fd_sc_hd__decap_6
XFILLER_0_3_15 VPWR VGND VPWR VGND sky130_ef_sc_hd__decap_12
XFILLER_0_2_128 VGND VGND VPWR VPWR sky130_fd_sc_hd__decap_3
XFILLER_0_13_60 VGND VGND VPWR VPWR sky130_fd_sc_hd__decap_4
X_150_ _111_ VGND VGND VPWR VPWR net6 sky130_fd_sc_hd__clkbuf_1
XFILLER_0_18_27 VGND VGND VPWR VPWR sky130_fd_sc_hd__fill_1
XPHY_EDGE_ROW_16_Right_16 VGND VGND VPWR VPWR sky130_fd_sc_hd__decap_3
X_133_ net5 _095_ _096_ _097_ _098_ VGND VGND VPWR VPWR _099_ sky130_fd_sc_hd__o221a_1
X_202_ _039_ _056_ interval_cnt\[8\] _030_ VGND VGND VPWR VPWR _011_ sky130_fd_sc_hd__o2bb2a_1
XFILLER_0_0_49 VGND VGND VPWR VPWR sky130_fd_sc_hd__decap_3
XFILLER_0_0_27 VGND VGND VPWR VPWR sky130_fd_sc_hd__fill_1
XFILLER_0_16_126 VGND VGND VPWR VPWR sky130_fd_sc_hd__decap_4
XPHY_EDGE_ROW_12_Left_34 VGND VGND VPWR VPWR sky130_fd_sc_hd__decap_3
XPHY_EDGE_ROW_2_Right_2 VGND VGND VPWR VPWR sky130_fd_sc_hd__decap_3
XFILLER_0_6_37 VGND VGND VPWR VPWR sky130_fd_sc_hd__decap_3
XFILLER_0_13_129 VGND VGND VPWR VPWR sky130_fd_sc_hd__fill_2
XFILLER_0_16_71 VPWR VGND VPWR VGND sky130_ef_sc_hd__decap_12
XFILLER_0_12_29 VGND VGND VPWR VPWR sky130_fd_sc_hd__decap_6
XFILLER_0_11_3 VPWR VGND VPWR VGND sky130_ef_sc_hd__decap_12
XFILLER_0_3_27 VGND VGND VPWR VPWR sky130_fd_sc_hd__decap_6
XFILLER_0_13_83 VGND VGND VPWR VPWR sky130_fd_sc_hd__fill_2
XPHY_EDGE_ROW_0_Left_22 VGND VGND VPWR VPWR sky130_fd_sc_hd__decap_3
XFILLER_0_0_3 VPWR VGND VPWR VGND sky130_ef_sc_hd__decap_12
XFILLER_0_20_29 VPWR VGND VPWR VGND sky130_ef_sc_hd__decap_12
X_132_ net4 VGND VGND VPWR VPWR _098_ sky130_fd_sc_hd__buf_2
X_201_ _040_ _055_ _107_ VGND VGND VPWR VPWR _056_ sky130_fd_sc_hd__o21ai_1
XFILLER_0_10_73 VGND VGND VPWR VPWR sky130_fd_sc_hd__decap_3
XFILLER_0_19_113 VPWR VGND VPWR VGND sky130_ef_sc_hd__decap_12
XTAP_TAPCELL_ROW_20_86 VGND VPWR sky130_fd_sc_hd__tapvpwrvgnd_1
XFILLER_0_16_105 VGND VGND VPWR VPWR sky130_fd_sc_hd__fill_1
XFILLER_0_16_83 VGND VGND VPWR VPWR sky130_fd_sc_hd__fill_1
XFILLER_0_6_16 VPWR VGND VPWR VGND sky130_ef_sc_hd__decap_12
Xoutput6 net6 VGND VGND VPWR VPWR buzzer sky130_fd_sc_hd__clkbuf_2
.ends
